* sim/dco: DCO cell-level bench (spec rows 2, 3; open items O1, O3).
* Pre-layout, ideal wires: electrical netlist of design/dco.v (same cells, same
* connectivity) with the tuning word set by .param cc (coarse) and fc (fine).
* Pre-layout simulated only; row 2/3 grading is post-layout (not this file).
.include $PDK_ROOT/sky130A/libs.ref/sky130_fd_sc_hd/spice/sky130_fd_sc_hd.spice
.param cc=32 fc=32
Vdd vdd 0 1.8
* enable: low for 1 ns (nodes settle), then released
Ven en 0 PWL(0 0 1n 0 1.1n 1.8)

Vc0 c0 0 {1.8*(floor(cc/1)-2*floor(cc/2))}
Vf0 f0 0 {1.8*(floor(fc/1)-2*floor(fc/2))}
Vc1 c1 0 {1.8*(floor(cc/2)-2*floor(cc/4))}
Vf1 f1 0 {1.8*(floor(fc/2)-2*floor(fc/4))}
Vc2 c2 0 {1.8*(floor(cc/4)-2*floor(cc/8))}
Vf2 f2 0 {1.8*(floor(fc/4)-2*floor(fc/8))}
Vc3 c3 0 {1.8*(floor(cc/8)-2*floor(cc/16))}
Vf3 f3 0 {1.8*(floor(fc/8)-2*floor(fc/16))}
Vc4 c4 0 {1.8*(floor(cc/16)-2*floor(cc/32))}
Vf4 f4 0 {1.8*(floor(fc/16)-2*floor(fc/32))}
Vc5 c5 0 {1.8*(floor(cc/32)-2*floor(cc/64))}
Vf5 f5 0 {1.8*(floor(fc/32)-2*floor(fc/64))}

* ring: n0 = NAND2(n4, en); n1..n4 = inv_2 chain (as design/dco.v)
Xs0 n4 en 0 0 vdd vdd n0 sky130_fd_sc_hd__nand2_2
Xs1 n0 0 0 vdd vdd n1 sky130_fd_sc_hd__inv_2
Xs2 n1 0 0 vdd vdd n2 sky130_fd_sc_hd__inv_2
Xs3 n2 0 0 vdd vdd n3 sky130_fd_sc_hd__inv_2
Xs4 n3 0 0 vdd vdd n4 sky130_fd_sc_hd__inv_2
* coarse bank: 2^k einvp_1 per bit k, A=n1 -> Z=n2
* fine bank:   2^k einvp_1 per bit k, A=n2 -> Z=n3
* einvp_1 ports: A TE VGND VNB VPB VPWR Z
Xcb0_0 n1 c0 0 0 vdd vdd n2 sky130_fd_sc_hd__einvp_1
Xcb1_0 n1 c1 0 0 vdd vdd n2 sky130_fd_sc_hd__einvp_1
Xcb1_1 n1 c1 0 0 vdd vdd n2 sky130_fd_sc_hd__einvp_1
Xcb2_0 n1 c2 0 0 vdd vdd n2 sky130_fd_sc_hd__einvp_1
Xcb2_1 n1 c2 0 0 vdd vdd n2 sky130_fd_sc_hd__einvp_1
Xcb2_2 n1 c2 0 0 vdd vdd n2 sky130_fd_sc_hd__einvp_1
Xcb2_3 n1 c2 0 0 vdd vdd n2 sky130_fd_sc_hd__einvp_1
Xcb3_0 n1 c3 0 0 vdd vdd n2 sky130_fd_sc_hd__einvp_1
Xcb3_1 n1 c3 0 0 vdd vdd n2 sky130_fd_sc_hd__einvp_1
Xcb3_2 n1 c3 0 0 vdd vdd n2 sky130_fd_sc_hd__einvp_1
Xcb3_3 n1 c3 0 0 vdd vdd n2 sky130_fd_sc_hd__einvp_1
Xcb3_4 n1 c3 0 0 vdd vdd n2 sky130_fd_sc_hd__einvp_1
Xcb3_5 n1 c3 0 0 vdd vdd n2 sky130_fd_sc_hd__einvp_1
Xcb3_6 n1 c3 0 0 vdd vdd n2 sky130_fd_sc_hd__einvp_1
Xcb3_7 n1 c3 0 0 vdd vdd n2 sky130_fd_sc_hd__einvp_1
Xcb4_0 n1 c4 0 0 vdd vdd n2 sky130_fd_sc_hd__einvp_1
Xcb4_1 n1 c4 0 0 vdd vdd n2 sky130_fd_sc_hd__einvp_1
Xcb4_2 n1 c4 0 0 vdd vdd n2 sky130_fd_sc_hd__einvp_1
Xcb4_3 n1 c4 0 0 vdd vdd n2 sky130_fd_sc_hd__einvp_1
Xcb4_4 n1 c4 0 0 vdd vdd n2 sky130_fd_sc_hd__einvp_1
Xcb4_5 n1 c4 0 0 vdd vdd n2 sky130_fd_sc_hd__einvp_1
Xcb4_6 n1 c4 0 0 vdd vdd n2 sky130_fd_sc_hd__einvp_1
Xcb4_7 n1 c4 0 0 vdd vdd n2 sky130_fd_sc_hd__einvp_1
Xcb4_8 n1 c4 0 0 vdd vdd n2 sky130_fd_sc_hd__einvp_1
Xcb4_9 n1 c4 0 0 vdd vdd n2 sky130_fd_sc_hd__einvp_1
Xcb4_10 n1 c4 0 0 vdd vdd n2 sky130_fd_sc_hd__einvp_1
Xcb4_11 n1 c4 0 0 vdd vdd n2 sky130_fd_sc_hd__einvp_1
Xcb4_12 n1 c4 0 0 vdd vdd n2 sky130_fd_sc_hd__einvp_1
Xcb4_13 n1 c4 0 0 vdd vdd n2 sky130_fd_sc_hd__einvp_1
Xcb4_14 n1 c4 0 0 vdd vdd n2 sky130_fd_sc_hd__einvp_1
Xcb4_15 n1 c4 0 0 vdd vdd n2 sky130_fd_sc_hd__einvp_1
Xcb5_0 n1 c5 0 0 vdd vdd n2 sky130_fd_sc_hd__einvp_1
Xcb5_1 n1 c5 0 0 vdd vdd n2 sky130_fd_sc_hd__einvp_1
Xcb5_2 n1 c5 0 0 vdd vdd n2 sky130_fd_sc_hd__einvp_1
Xcb5_3 n1 c5 0 0 vdd vdd n2 sky130_fd_sc_hd__einvp_1
Xcb5_4 n1 c5 0 0 vdd vdd n2 sky130_fd_sc_hd__einvp_1
Xcb5_5 n1 c5 0 0 vdd vdd n2 sky130_fd_sc_hd__einvp_1
Xcb5_6 n1 c5 0 0 vdd vdd n2 sky130_fd_sc_hd__einvp_1
Xcb5_7 n1 c5 0 0 vdd vdd n2 sky130_fd_sc_hd__einvp_1
Xcb5_8 n1 c5 0 0 vdd vdd n2 sky130_fd_sc_hd__einvp_1
Xcb5_9 n1 c5 0 0 vdd vdd n2 sky130_fd_sc_hd__einvp_1
Xcb5_10 n1 c5 0 0 vdd vdd n2 sky130_fd_sc_hd__einvp_1
Xcb5_11 n1 c5 0 0 vdd vdd n2 sky130_fd_sc_hd__einvp_1
Xcb5_12 n1 c5 0 0 vdd vdd n2 sky130_fd_sc_hd__einvp_1
Xcb5_13 n1 c5 0 0 vdd vdd n2 sky130_fd_sc_hd__einvp_1
Xcb5_14 n1 c5 0 0 vdd vdd n2 sky130_fd_sc_hd__einvp_1
Xcb5_15 n1 c5 0 0 vdd vdd n2 sky130_fd_sc_hd__einvp_1
Xcb5_16 n1 c5 0 0 vdd vdd n2 sky130_fd_sc_hd__einvp_1
Xcb5_17 n1 c5 0 0 vdd vdd n2 sky130_fd_sc_hd__einvp_1
Xcb5_18 n1 c5 0 0 vdd vdd n2 sky130_fd_sc_hd__einvp_1
Xcb5_19 n1 c5 0 0 vdd vdd n2 sky130_fd_sc_hd__einvp_1
Xcb5_20 n1 c5 0 0 vdd vdd n2 sky130_fd_sc_hd__einvp_1
Xcb5_21 n1 c5 0 0 vdd vdd n2 sky130_fd_sc_hd__einvp_1
Xcb5_22 n1 c5 0 0 vdd vdd n2 sky130_fd_sc_hd__einvp_1
Xcb5_23 n1 c5 0 0 vdd vdd n2 sky130_fd_sc_hd__einvp_1
Xcb5_24 n1 c5 0 0 vdd vdd n2 sky130_fd_sc_hd__einvp_1
Xcb5_25 n1 c5 0 0 vdd vdd n2 sky130_fd_sc_hd__einvp_1
Xcb5_26 n1 c5 0 0 vdd vdd n2 sky130_fd_sc_hd__einvp_1
Xcb5_27 n1 c5 0 0 vdd vdd n2 sky130_fd_sc_hd__einvp_1
Xcb5_28 n1 c5 0 0 vdd vdd n2 sky130_fd_sc_hd__einvp_1
Xcb5_29 n1 c5 0 0 vdd vdd n2 sky130_fd_sc_hd__einvp_1
Xcb5_30 n1 c5 0 0 vdd vdd n2 sky130_fd_sc_hd__einvp_1
Xcb5_31 n1 c5 0 0 vdd vdd n2 sky130_fd_sc_hd__einvp_1
Xfb0_0 n2 f0 0 0 vdd vdd n3 sky130_fd_sc_hd__einvp_1
Xfb1_0 n2 f1 0 0 vdd vdd n3 sky130_fd_sc_hd__einvp_1
Xfb1_1 n2 f1 0 0 vdd vdd n3 sky130_fd_sc_hd__einvp_1
Xfb2_0 n2 f2 0 0 vdd vdd n3 sky130_fd_sc_hd__einvp_1
Xfb2_1 n2 f2 0 0 vdd vdd n3 sky130_fd_sc_hd__einvp_1
Xfb2_2 n2 f2 0 0 vdd vdd n3 sky130_fd_sc_hd__einvp_1
Xfb2_3 n2 f2 0 0 vdd vdd n3 sky130_fd_sc_hd__einvp_1
Xfb3_0 n2 f3 0 0 vdd vdd n3 sky130_fd_sc_hd__einvp_1
Xfb3_1 n2 f3 0 0 vdd vdd n3 sky130_fd_sc_hd__einvp_1
Xfb3_2 n2 f3 0 0 vdd vdd n3 sky130_fd_sc_hd__einvp_1
Xfb3_3 n2 f3 0 0 vdd vdd n3 sky130_fd_sc_hd__einvp_1
Xfb3_4 n2 f3 0 0 vdd vdd n3 sky130_fd_sc_hd__einvp_1
Xfb3_5 n2 f3 0 0 vdd vdd n3 sky130_fd_sc_hd__einvp_1
Xfb3_6 n2 f3 0 0 vdd vdd n3 sky130_fd_sc_hd__einvp_1
Xfb3_7 n2 f3 0 0 vdd vdd n3 sky130_fd_sc_hd__einvp_1
Xfb4_0 n2 f4 0 0 vdd vdd n3 sky130_fd_sc_hd__einvp_1
Xfb4_1 n2 f4 0 0 vdd vdd n3 sky130_fd_sc_hd__einvp_1
Xfb4_2 n2 f4 0 0 vdd vdd n3 sky130_fd_sc_hd__einvp_1
Xfb4_3 n2 f4 0 0 vdd vdd n3 sky130_fd_sc_hd__einvp_1
Xfb4_4 n2 f4 0 0 vdd vdd n3 sky130_fd_sc_hd__einvp_1
Xfb4_5 n2 f4 0 0 vdd vdd n3 sky130_fd_sc_hd__einvp_1
Xfb4_6 n2 f4 0 0 vdd vdd n3 sky130_fd_sc_hd__einvp_1
Xfb4_7 n2 f4 0 0 vdd vdd n3 sky130_fd_sc_hd__einvp_1
Xfb4_8 n2 f4 0 0 vdd vdd n3 sky130_fd_sc_hd__einvp_1
Xfb4_9 n2 f4 0 0 vdd vdd n3 sky130_fd_sc_hd__einvp_1
Xfb4_10 n2 f4 0 0 vdd vdd n3 sky130_fd_sc_hd__einvp_1
Xfb4_11 n2 f4 0 0 vdd vdd n3 sky130_fd_sc_hd__einvp_1
Xfb4_12 n2 f4 0 0 vdd vdd n3 sky130_fd_sc_hd__einvp_1
Xfb4_13 n2 f4 0 0 vdd vdd n3 sky130_fd_sc_hd__einvp_1
Xfb4_14 n2 f4 0 0 vdd vdd n3 sky130_fd_sc_hd__einvp_1
Xfb4_15 n2 f4 0 0 vdd vdd n3 sky130_fd_sc_hd__einvp_1
Xfb5_0 n2 f5 0 0 vdd vdd n3 sky130_fd_sc_hd__einvp_1
Xfb5_1 n2 f5 0 0 vdd vdd n3 sky130_fd_sc_hd__einvp_1
Xfb5_2 n2 f5 0 0 vdd vdd n3 sky130_fd_sc_hd__einvp_1
Xfb5_3 n2 f5 0 0 vdd vdd n3 sky130_fd_sc_hd__einvp_1
Xfb5_4 n2 f5 0 0 vdd vdd n3 sky130_fd_sc_hd__einvp_1
Xfb5_5 n2 f5 0 0 vdd vdd n3 sky130_fd_sc_hd__einvp_1
Xfb5_6 n2 f5 0 0 vdd vdd n3 sky130_fd_sc_hd__einvp_1
Xfb5_7 n2 f5 0 0 vdd vdd n3 sky130_fd_sc_hd__einvp_1
Xfb5_8 n2 f5 0 0 vdd vdd n3 sky130_fd_sc_hd__einvp_1
Xfb5_9 n2 f5 0 0 vdd vdd n3 sky130_fd_sc_hd__einvp_1
Xfb5_10 n2 f5 0 0 vdd vdd n3 sky130_fd_sc_hd__einvp_1
Xfb5_11 n2 f5 0 0 vdd vdd n3 sky130_fd_sc_hd__einvp_1
Xfb5_12 n2 f5 0 0 vdd vdd n3 sky130_fd_sc_hd__einvp_1
Xfb5_13 n2 f5 0 0 vdd vdd n3 sky130_fd_sc_hd__einvp_1
Xfb5_14 n2 f5 0 0 vdd vdd n3 sky130_fd_sc_hd__einvp_1
Xfb5_15 n2 f5 0 0 vdd vdd n3 sky130_fd_sc_hd__einvp_1
Xfb5_16 n2 f5 0 0 vdd vdd n3 sky130_fd_sc_hd__einvp_1
Xfb5_17 n2 f5 0 0 vdd vdd n3 sky130_fd_sc_hd__einvp_1
Xfb5_18 n2 f5 0 0 vdd vdd n3 sky130_fd_sc_hd__einvp_1
Xfb5_19 n2 f5 0 0 vdd vdd n3 sky130_fd_sc_hd__einvp_1
Xfb5_20 n2 f5 0 0 vdd vdd n3 sky130_fd_sc_hd__einvp_1
Xfb5_21 n2 f5 0 0 vdd vdd n3 sky130_fd_sc_hd__einvp_1
Xfb5_22 n2 f5 0 0 vdd vdd n3 sky130_fd_sc_hd__einvp_1
Xfb5_23 n2 f5 0 0 vdd vdd n3 sky130_fd_sc_hd__einvp_1
Xfb5_24 n2 f5 0 0 vdd vdd n3 sky130_fd_sc_hd__einvp_1
Xfb5_25 n2 f5 0 0 vdd vdd n3 sky130_fd_sc_hd__einvp_1
Xfb5_26 n2 f5 0 0 vdd vdd n3 sky130_fd_sc_hd__einvp_1
Xfb5_27 n2 f5 0 0 vdd vdd n3 sky130_fd_sc_hd__einvp_1
Xfb5_28 n2 f5 0 0 vdd vdd n3 sky130_fd_sc_hd__einvp_1
Xfb5_29 n2 f5 0 0 vdd vdd n3 sky130_fd_sc_hd__einvp_1
Xfb5_30 n2 f5 0 0 vdd vdd n3 sky130_fd_sc_hd__einvp_1
Xfb5_31 n2 f5 0 0 vdd vdd n3 sky130_fd_sc_hd__einvp_1

* output buffer (inv_4) driving a fixed 10 fF probe load
Xout n4 0 0 vdd vdd clk sky130_fd_sc_hd__inv_4
Cload clk 0 10f
